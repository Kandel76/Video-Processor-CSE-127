* Auto-generated black-box SPICE for photodiode_layout

.SUBCKT photodiode_layout VDD GND ROW_SELECT[0] ROW_SELECT[1] ROW_SELECT[2] ROW_SELECT[3] ROW_SELECT[4] ROW_SELECT[5] ROW_SELECT[6] ROW_SELECT[7] ROW_SELECT[8] ROW_SELECT[9] ROW_SELECT[10] ROW_SELECT[11] ROW_SELECT[12] ROW_SELECT[13] ROW_SELECT[14] ROW_SELECT[15] ROW_SELECT[16] ROW_SELECT[17] ROW_SELECT[18] ROW_SELECT[19] ROW_SELECT[20] ROW_SELECT[21] ROW_SELECT[22] ROW_SELECT[23] ROW_SELECT[24] ROW_SELECT[25] ROW_SELECT[26] ROW_SELECT[27] ROW_SELECT[28] ROW_SELECT[29] ROW_SELECT[30] ROW_SELECT[31] ROW_SELECT[32] ROW_SELECT[33] ROW_SELECT[34] ROW_SELECT[35] ROW_SELECT[36] ROW_SELECT[37] ROW_SELECT[38] ROW_SELECT[39] ROW_SELECT[40] ROW_SELECT[41] ROW_SELECT[42] ROW_SELECT[43] ROW_SELECT[44] ROW_SELECT[45] ROW_SELECT[46] ROW_SELECT[47] ROW_SELECT[48] ROW_SELECT[49] ROW_SELECT[50] ROW_SELECT[51] ROW_SELECT[52] ROW_SELECT[53] ROW_SELECT[54] ROW_SELECT[55] ROW_SELECT[56] ROW_SELECT[57] ROW_SELECT[58] ROW_SELECT[59] ROW_SELECT[60] ROW_SELECT[61] ROW_SELECT[62] ROW_SELECT[63] ROW_SELECT[64] ROW_SELECT[65] ROW_SELECT[66] ROW_SELECT[67] ROW_SELECT[68] ROW_SELECT[69] ROW_SELECT[70] ROW_SELECT[71] ROW_SELECT[72] ROW_SELECT[73] ROW_SELECT[74] ROW_SELECT[75] ROW_SELECT[76] ROW_SELECT[77] ROW_SELECT[78] ROW_SELECT[79] ROW_SELECT[80] ROW_SELECT[81] ROW_SELECT[82] ROW_SELECT[83] ROW_SELECT[84] ROW_SELECT[85] ROW_SELECT[86] ROW_SELECT[87] ROW_SELECT[88] ROW_SELECT[89] ROW_SELECT[90] ROW_SELECT[91] ROW_SELECT[92] ROW_SELECT[93] ROW_SELECT[94] ROW_SELECT[95] ROW_SELECT[96] ROW_SELECT[97] ROW_SELECT[98] ROW_SELECT[99] ROW_SELECT[100] ROW_SELECT[101] ROW_SELECT[102] ROW_SELECT[103] ROW_SELECT[104] ROW_SELECT[105] ROW_SELECT[106] ROW_SELECT[107] ROW_SELECT[108] ROW_SELECT[109] ROW_SELECT[110] ROW_SELECT[111] ROW_SELECT[112] ROW_SELECT[113] ROW_SELECT[114] ROW_SELECT[115] ROW_SELECT[116] ROW_SELECT[117] ROW_SELECT[118] ROW_SELECT[119] ROW_SELECT[120] ROW_SELECT[121] ROW_SELECT[122] ROW_SELECT[123] ROW_SELECT[124] ROW_SELECT[125] ROW_SELECT[126] ROW_SELECT[127] ROW_SELECT[128] ROW_SELECT[129] ROW_SELECT[130] ROW_SELECT[131] ROW_SELECT[132] ROW_SELECT[133] ROW_SELECT[134] ROW_SELECT[135] ROW_SELECT[136] ROW_SELECT[137] ROW_SELECT[138] ROW_SELECT[139] ROW_SELECT[140] ROW_SELECT[141] ROW_SELECT[142] ROW_SELECT[143] ROW_SELECT[144] ROW_SELECT[145] ROW_SELECT[146] ROW_SELECT[147] ROW_SELECT[148] ROW_SELECT[149] ROW_SELECT[150] ROW_SELECT[151] ROW_SELECT[152] ROW_SELECT[153] ROW_SELECT[154] ROW_SELECT[155] ROW_SELECT[156] ROW_SELECT[157] ROW_SELECT[158] ROW_SELECT[159] ROW_SELECT[160] ROW_SELECT[161] ROW_SELECT[162] ROW_SELECT[163] ROW_SELECT[164] ROW_SELECT[165] ROW_SELECT[166] ROW_SELECT[167] ROW_SELECT[168] ROW_SELECT[169] ROW_SELECT[170] ROW_SELECT[171] ROW_SELECT[172] ROW_SELECT[173] ROW_SELECT[174] ROW_SELECT[175] ROW_SELECT[176] ROW_SELECT[177] ROW_SELECT[178] ROW_SELECT[179] ROW_SELECT[180] ROW_SELECT[181] ROW_SELECT[182] ROW_SELECT[183] ROW_SELECT[184] ROW_SELECT[185] ROW_SELECT[186] ROW_SELECT[187] ROW_SELECT[188] ROW_SELECT[189] ROW_SELECT[190] ROW_SELECT[191] ROW_SELECT[192] ROW_SELECT[193] ROW_SELECT[194] ROW_SELECT[195] ROW_SELECT[196] ROW_SELECT[197] ROW_SELECT[198] ROW_SELECT[199] ROW_SELECT[200] ROW_SELECT[201] ROW_SELECT[202] ROW_SELECT[203] ROW_SELECT[204] ROW_SELECT[205] ROW_SELECT[206] ROW_SELECT[207] ROW_SELECT[208] ROW_SELECT[209] ROW_SELECT[210] ROW_SELECT[211] ROW_SELECT[212] ROW_SELECT[213] ROW_SELECT[214] ROW_SELECT[215] ROW_SELECT[216] ROW_SELECT[217] ROW_SELECT[218] ROW_SELECT[219] ROW_SELECT[220] ROW_SELECT[221] ROW_SELECT[222] ROW_SELECT[223] ROW_SELECT[224] ROW_SELECT[225] ROW_SELECT[226] ROW_SELECT[227] ROW_SELECT[228] ROW_SELECT[229] ROW_SELECT[230] ROW_SELECT[231] ROW_SELECT[232] ROW_SELECT[233] ROW_SELECT[234] ROW_SELECT[235] ROW_SELECT[236] ROW_SELECT[237] ROW_SELECT[238] ROW_SELECT[239] RESET[0] RESET[1] RESET[2] RESET[3] RESET[4] RESET[5] RESET[6] RESET[7] RESET[8] RESET[9] RESET[10] RESET[11] RESET[12] RESET[13] RESET[14] RESET[15] RESET[16] RESET[17] RESET[18] RESET[19] RESET[20] RESET[21] RESET[22] RESET[23] RESET[24] RESET[25] RESET[26] RESET[27] RESET[28] RESET[29] RESET[30] RESET[31] RESET[32] RESET[33] RESET[34] RESET[35] RESET[36] RESET[37] RESET[38] RESET[39] RESET[40] RESET[41] RESET[42] RESET[43] RESET[44] RESET[45] RESET[46] RESET[47] RESET[48] RESET[49] RESET[50] RESET[51] RESET[52] RESET[53] RESET[54] RESET[55] RESET[56] RESET[57] RESET[58] RESET[59] RESET[60] RESET[61] RESET[62] RESET[63] RESET[64] RESET[65] RESET[66] RESET[67] RESET[68] RESET[69] RESET[70] RESET[71] RESET[72] RESET[73] RESET[74] RESET[75] RESET[76] RESET[77] RESET[78] RESET[79] RESET[80] RESET[81] RESET[82] RESET[83] RESET[84] RESET[85] RESET[86] RESET[87] RESET[88] RESET[89] RESET[90] RESET[91] RESET[92] RESET[93] RESET[94] RESET[95] RESET[96] RESET[97] RESET[98] RESET[99] RESET[100] RESET[101] RESET[102] RESET[103] RESET[104] RESET[105] RESET[106] RESET[107] RESET[108] RESET[109] RESET[110] RESET[111] RESET[112] RESET[113] RESET[114] RESET[115] RESET[116] RESET[117] RESET[118] RESET[119] RESET[120] RESET[121] RESET[122] RESET[123] RESET[124] RESET[125] RESET[126] RESET[127] RESET[128] RESET[129] RESET[130] RESET[131] RESET[132] RESET[133] RESET[134] RESET[135] RESET[136] RESET[137] RESET[138] RESET[139] RESET[140] RESET[141] RESET[142] RESET[143] RESET[144] RESET[145] RESET[146] RESET[147] RESET[148] RESET[149] RESET[150] RESET[151] RESET[152] RESET[153] RESET[154] RESET[155] RESET[156] RESET[157] RESET[158] RESET[159] RESET[160] RESET[161] RESET[162] RESET[163] RESET[164] RESET[165] RESET[166] RESET[167] RESET[168] RESET[169] RESET[170] RESET[171] RESET[172] RESET[173] RESET[174] RESET[175] RESET[176] RESET[177] RESET[178] RESET[179] RESET[180] RESET[181] RESET[182] RESET[183] RESET[184] RESET[185] RESET[186] RESET[187] RESET[188] RESET[189] RESET[190] RESET[191] RESET[192] RESET[193] RESET[194] RESET[195] RESET[196] RESET[197] RESET[198] RESET[199] RESET[200] RESET[201] RESET[202] RESET[203] RESET[204] RESET[205] RESET[206] RESET[207] RESET[208] RESET[209] RESET[210] RESET[211] RESET[212] RESET[213] RESET[214] RESET[215] RESET[216] RESET[217] RESET[218] RESET[219] RESET[220] RESET[221] RESET[222] RESET[223] RESET[224] RESET[225] RESET[226] RESET[227] RESET[228] RESET[229] RESET[230] RESET[231] RESET[232] RESET[233] RESET[234] RESET[235] RESET[236] RESET[237] RESET[238] RESET[239] COLUMN_OUT[0] COLUMN_OUT[1] COLUMN_OUT[2] COLUMN_OUT[3] COLUMN_OUT[4] COLUMN_OUT[5] COLUMN_OUT[6] COLUMN_OUT[7] COLUMN_OUT[8] COLUMN_OUT[9] COLUMN_OUT[10] COLUMN_OUT[11] COLUMN_OUT[12] COLUMN_OUT[13] COLUMN_OUT[14] COLUMN_OUT[15] COLUMN_OUT[16] COLUMN_OUT[17] COLUMN_OUT[18] COLUMN_OUT[19] COLUMN_OUT[20] COLUMN_OUT[21] COLUMN_OUT[22] COLUMN_OUT[23] COLUMN_OUT[24] COLUMN_OUT[25] COLUMN_OUT[26] COLUMN_OUT[27] COLUMN_OUT[28] COLUMN_OUT[29] COLUMN_OUT[30] COLUMN_OUT[31] COLUMN_OUT[32] COLUMN_OUT[33] COLUMN_OUT[34] COLUMN_OUT[35] COLUMN_OUT[36] COLUMN_OUT[37] COLUMN_OUT[38] COLUMN_OUT[39] COLUMN_OUT[40] COLUMN_OUT[41] COLUMN_OUT[42] COLUMN_OUT[43] COLUMN_OUT[44] COLUMN_OUT[45] COLUMN_OUT[46] COLUMN_OUT[47] COLUMN_OUT[48] COLUMN_OUT[49] COLUMN_OUT[50] COLUMN_OUT[51] COLUMN_OUT[52] COLUMN_OUT[53] COLUMN_OUT[54] COLUMN_OUT[55] COLUMN_OUT[56] COLUMN_OUT[57] COLUMN_OUT[58] COLUMN_OUT[59] COLUMN_OUT[60] COLUMN_OUT[61] COLUMN_OUT[62] COLUMN_OUT[63] COLUMN_OUT[64] COLUMN_OUT[65] COLUMN_OUT[66] COLUMN_OUT[67] COLUMN_OUT[68] COLUMN_OUT[69] COLUMN_OUT[70] COLUMN_OUT[71] COLUMN_OUT[72] COLUMN_OUT[73] COLUMN_OUT[74] COLUMN_OUT[75] COLUMN_OUT[76] COLUMN_OUT[77] COLUMN_OUT[78] COLUMN_OUT[79] COLUMN_OUT[80] COLUMN_OUT[81] COLUMN_OUT[82] COLUMN_OUT[83] COLUMN_OUT[84] COLUMN_OUT[85] COLUMN_OUT[86] COLUMN_OUT[87] COLUMN_OUT[88] COLUMN_OUT[89] COLUMN_OUT[90] COLUMN_OUT[91] COLUMN_OUT[92] COLUMN_OUT[93] COLUMN_OUT[94] COLUMN_OUT[95] COLUMN_OUT[96] COLUMN_OUT[97] COLUMN_OUT[98] COLUMN_OUT[99] COLUMN_OUT[100] COLUMN_OUT[101] COLUMN_OUT[102] COLUMN_OUT[103] COLUMN_OUT[104] COLUMN_OUT[105] COLUMN_OUT[106] COLUMN_OUT[107] COLUMN_OUT[108] COLUMN_OUT[109] COLUMN_OUT[110] COLUMN_OUT[111] COLUMN_OUT[112] COLUMN_OUT[113] COLUMN_OUT[114] COLUMN_OUT[115] COLUMN_OUT[116] COLUMN_OUT[117] COLUMN_OUT[118] COLUMN_OUT[119] COLUMN_OUT[120] COLUMN_OUT[121] COLUMN_OUT[122] COLUMN_OUT[123] COLUMN_OUT[124] COLUMN_OUT[125] COLUMN_OUT[126] COLUMN_OUT[127] COLUMN_OUT[128] COLUMN_OUT[129] COLUMN_OUT[130] COLUMN_OUT[131] COLUMN_OUT[132] COLUMN_OUT[133] COLUMN_OUT[134] COLUMN_OUT[135] COLUMN_OUT[136] COLUMN_OUT[137] COLUMN_OUT[138] COLUMN_OUT[139] COLUMN_OUT[140] COLUMN_OUT[141] COLUMN_OUT[142] COLUMN_OUT[143] COLUMN_OUT[144] COLUMN_OUT[145] COLUMN_OUT[146] COLUMN_OUT[147] COLUMN_OUT[148] COLUMN_OUT[149] COLUMN_OUT[150] COLUMN_OUT[151] COLUMN_OUT[152] COLUMN_OUT[153] COLUMN_OUT[154] COLUMN_OUT[155] COLUMN_OUT[156] COLUMN_OUT[157] COLUMN_OUT[158] COLUMN_OUT[159] COLUMN_OUT[160] COLUMN_OUT[161] COLUMN_OUT[162] COLUMN_OUT[163] COLUMN_OUT[164] COLUMN_OUT[165] COLUMN_OUT[166] COLUMN_OUT[167] COLUMN_OUT[168] COLUMN_OUT[169] COLUMN_OUT[170] COLUMN_OUT[171] COLUMN_OUT[172] COLUMN_OUT[173] COLUMN_OUT[174] COLUMN_OUT[175] COLUMN_OUT[176] COLUMN_OUT[177] COLUMN_OUT[178] COLUMN_OUT[179] COLUMN_OUT[180] COLUMN_OUT[181] COLUMN_OUT[182] COLUMN_OUT[183] COLUMN_OUT[184] COLUMN_OUT[185] COLUMN_OUT[186] COLUMN_OUT[187] COLUMN_OUT[188] COLUMN_OUT[189] COLUMN_OUT[190] COLUMN_OUT[191] COLUMN_OUT[192] COLUMN_OUT[193] COLUMN_OUT[194] COLUMN_OUT[195] COLUMN_OUT[196] COLUMN_OUT[197] COLUMN_OUT[198] COLUMN_OUT[199] COLUMN_OUT[200] COLUMN_OUT[201] COLUMN_OUT[202] COLUMN_OUT[203] COLUMN_OUT[204] COLUMN_OUT[205] COLUMN_OUT[206] COLUMN_OUT[207] COLUMN_OUT[208] COLUMN_OUT[209] COLUMN_OUT[210] COLUMN_OUT[211] COLUMN_OUT[212] COLUMN_OUT[213] COLUMN_OUT[214] COLUMN_OUT[215] COLUMN_OUT[216] COLUMN_OUT[217] COLUMN_OUT[218] COLUMN_OUT[219] COLUMN_OUT[220] COLUMN_OUT[221] COLUMN_OUT[222] COLUMN_OUT[223] COLUMN_OUT[224] COLUMN_OUT[225] COLUMN_OUT[226] COLUMN_OUT[227] COLUMN_OUT[228] COLUMN_OUT[229] COLUMN_OUT[230] COLUMN_OUT[231] COLUMN_OUT[232] COLUMN_OUT[233] COLUMN_OUT[234] COLUMN_OUT[235] COLUMN_OUT[236] COLUMN_OUT[237] COLUMN_OUT[238] COLUMN_OUT[239] COLUMN_OUT[240] COLUMN_OUT[241] COLUMN_OUT[242] COLUMN_OUT[243] COLUMN_OUT[244] COLUMN_OUT[245] COLUMN_OUT[246] COLUMN_OUT[247] COLUMN_OUT[248] COLUMN_OUT[249] COLUMN_OUT[250] COLUMN_OUT[251] COLUMN_OUT[252] COLUMN_OUT[253] COLUMN_OUT[254] COLUMN_OUT[255] COLUMN_OUT[256] COLUMN_OUT[257] COLUMN_OUT[258] COLUMN_OUT[259] COLUMN_OUT[260] COLUMN_OUT[261] COLUMN_OUT[262] COLUMN_OUT[263] COLUMN_OUT[264] COLUMN_OUT[265] COLUMN_OUT[266] COLUMN_OUT[267] COLUMN_OUT[268] COLUMN_OUT[269] COLUMN_OUT[270] COLUMN_OUT[271] COLUMN_OUT[272] COLUMN_OUT[273] COLUMN_OUT[274] COLUMN_OUT[275] COLUMN_OUT[276] COLUMN_OUT[277] COLUMN_OUT[278] COLUMN_OUT[279] COLUMN_OUT[280] COLUMN_OUT[281] COLUMN_OUT[282] COLUMN_OUT[283] COLUMN_OUT[284] COLUMN_OUT[285] COLUMN_OUT[286] COLUMN_OUT[287] COLUMN_OUT[288] COLUMN_OUT[289] COLUMN_OUT[290] COLUMN_OUT[291] COLUMN_OUT[292] COLUMN_OUT[293] COLUMN_OUT[294] COLUMN_OUT[295] COLUMN_OUT[296] COLUMN_OUT[297] COLUMN_OUT[298] COLUMN_OUT[299] COLUMN_OUT[300] COLUMN_OUT[301] COLUMN_OUT[302] COLUMN_OUT[303] COLUMN_OUT[304] COLUMN_OUT[305] COLUMN_OUT[306] COLUMN_OUT[307] COLUMN_OUT[308] COLUMN_OUT[309] COLUMN_OUT[310] COLUMN_OUT[311] COLUMN_OUT[312] COLUMN_OUT[313] COLUMN_OUT[314] COLUMN_OUT[315] COLUMN_OUT[316] COLUMN_OUT[317] COLUMN_OUT[318] COLUMN_OUT[319] COLUMN_OUT[320]

* Black box macro

.ENDS photodiode_layout
